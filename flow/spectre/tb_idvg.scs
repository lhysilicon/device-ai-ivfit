simulator lang=spectre
* Teaching testbench: extracted Verilog-A DC Id-Vg. Not a foundry PDK.
ahdl_include "../../models/nmos_extracted.va"

parameters vg=-0.1
Vgs (g 0) vsource dc=vg
Vds (d 0) vsource dc=1.5
N1 (d g 0) nmos_extracted

dc sweep param=vg start=-0.1 stop=1.5 step=0.05
